* AquaSDR analog front end: PA4 -> 2nd-order Sallen-Key LPF -> gain stage -> scope
* Generated by design_afe.py. Op-amp: one-pole VCVS, A0=1e5, GBW=10 MHz (TLV9062 datasheet).
VCC VCC 0 5.0
V3V3 V3V3 0 3.3
VIN DAC_PA4 0 DC 1.65 AC 1 SIN(1.65 0.7 40k)
R1 DAC_PA4 SK_A 4750
R2 SK_A SK_P 4750
C1 SK_A FILTER_OUT 6.8e-10
C2 SK_P 0 3.3e-10
EU1A FILTER_OUT_I 0 SK_P FILTER_OUT 1e5  ; ideal VCVS
RU1AP FILTER_OUT_I FILTER_OUT 15.9155  ; GBW pole with 1 nF
CU1AP FILTER_OUT 0 1n
C3 FILTER_OUT B_IN 1e-06
R3 VCC VMID 100000
R4 VMID 0 100000
C4 VMID 0 1e-07
R9 VMID B_IN 100000
EU1B OPAMP_OUT_I 0 B_IN FB 1e5  ; ideal VCVS
RU1BP OPAMP_OUT_I OPAMP_OUT 15.9155  ; GBW pole with 1 nF
CU1BP OPAMP_OUT 0 1n
R5 OPAMP_OUT FB 10000
R6 FB RG 20000
C5 RG 0 1e-05
R7 OPAMP_OUT SCOPE_AC 100
C6 SCOPE_AC SCOPE_OUT 1e-06
R8 SCOPE_OUT VBIAS 100000
R11 V3V3 VBIAS 10000
R12 VBIAS 0 10000
C9 VBIAS 0 1e-07
R10 SCOPE_OUT ADC_IN 1000
RLOAD SCOPE_OUT 0 1Meg
CADC ADC_IN 0 8e-12  ; model only
.ac dec 200 100 2Meg
.tran 1u 12m
.end
